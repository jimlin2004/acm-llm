* RC low-pass filter — simple analog test circuit
* Vào: nút "in", Ra: nút "out". R=1k, C=159nF -> f_3dB ~ 1kHz
V1 in 0 AC 1
R1 in out 1k
C1 out 0 159n
.ac dec 10 10 1Meg
.end
